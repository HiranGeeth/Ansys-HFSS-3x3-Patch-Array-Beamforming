# Ansys Electronics Desktop project, version 2025.2
project variables:
  $PhaseShift = 0deg
materials:
  vacuum: permittivity=1

design HFSSDesign1 (HFSS, HFSS Hybrid Terminal Network, model units mm)
variables:
  PhaseShift = 0deg
geometry:
  Patch_ProbeFed1 = component(Patch_ProbeFed, 3D_Component_File_Path=<syslib>/3DComponents/HFSS/Antennas/Patch/Patch_ProbeFed_DT.a3dcomp, subH=31mil, feedX=0cm, patchY=4.18cm, feedY=0.81cm, coax_outer_rad=0.354cm, feed_length=2.08cm, patchX=4.94cm, subX=7.9cm, subY=6.7cm, coax_inner_rad=0.104cm)
  sub [my_mat_ADK] = part_of(Patch_ProbeFed1)
  Ground, patch, feed_pin, coax_pin [pec] = part_of(Patch_ProbeFed1)
  coax [Teflon (tm)] = part_of(Patch_ProbeFed1)
  port1 [vacuum] = part_of(Patch_ProbeFed1)
  port_cap [pec] = part_of(Patch_ProbeFed1)
  Patch_ProbeFed1.placement()
  RadiatingSurface [vacuum] = region(absolute_offset: +X=0mm, -X=0mm, +Y=0mm, -Y=0mm, +Z=10mm, -Z=10mm)
boundaries and excitations:
  Patch_ProbeFed1_Ground: Perfect E Objects=Ground
  Patch_ProbeFed1_Patch: Perfect E Objects=patch
  Patch_ProbeFed1_coax_outer: Perfect E Faces=coax.face(at (-3.54, 8.1, -10.4))
  Open1: Radiation Objects=RadiatingSurface
  LatticePairX: Lattice Pair Faces=RadiatingSurface.face(+x, -x) CoordSysVector{(39.5, -33.5, -30.87874) -> (39.5, 33.5, -30.87874)} PhaseDelay=UseScanAngle Phi=0deg Theta=0deg
  LatticePairY: Lattice Pair Faces=RadiatingSurface.face(-y, +y) CoordSysVector{(39.5, -33.5, -30.87874) -> (39.5, -33.5, 10.7874)} ReverseV PhaseDelay=UseScanAngle Phi=0deg Theta=0deg
  Patch_ProbeFed1_coax_pin_T1: Terminal port=Patch_ProbeFed1_1 Faces=coax_pin.face(at (0, 8.1, -20.8)) TerminalResistance=50ohm
  Patch_ProbeFed1_1: Wave Port Faces=port1.face(at (0, 8.1, -20.8)) WavePortType=Terminal NumModes=1
setups:
  Setup1: HfssDrivenAuto AutoSolverSetting="Higher Speed" InfiniteSphereSetup=1 Type=Discrete
    sweep Sweep: 2.85GHz to 2.89GHz, 10 points;
source amplitudes:
  Patch_ProbeFed1_1:1, Patch_ProbeFed1_1:4, Patch_ProbeFed1_1:7: 1V 0deg
  Patch_ProbeFed1_1:2, Patch_ProbeFed1_1:5, Patch_ProbeFed1_1:8: 1V PhaseShift
  Patch_ProbeFed1_1:3, Patch_ProbeFed1_1:6, Patch_ProbeFed1_1:9: 1V 2*PhaseShift
optimetrics:
  ParametricSetup1: Parametric Sim._Setups=[Setup1]
    sweep PhaseShift: LIN -90deg 90deg 7deg
radiation setups:
  3D: Infinite Sphere Theta=0deg..180deg step 2deg Phi=-180deg..180deg step 2deg
  Elevation: Infinite Sphere Theta=-180deg..180deg step 1deg Phi=0deg..90deg step 90deg
  Azimuth: Infinite Sphere Theta=90deg..90deg step 0deg Phi=-180deg..180deg step 1deg
  Source Group1: Source Context  Sources=#A1[1,1]Patch_ProbeFed1_coax_pin_T1, #A1[1,2]Patch_ProbeFed1_coax_pin_T1, #A1[1,3]Patch_ProbeFed1_coax_pin_T1, #A1[2,1]Patch_ProbeFed1_coax_pin_T1, #A1[2,2]Patch_ProbeFed1_coax_pin_T1, #A1[2,3]Patch_ProbeFed1_coax_pin_T1, #A1[3,1]Patch_ProbeFed1_coax_pin_T1, #A1[3,2]Patch_ProbeFed1_coax_pin_T1, #A1[3,3]Patch_ProbeFed1_coax_pin_T1
reports:
  Gain Plot1: dB(GainTotal) vs Phi, Theta on Setup1 : Sweep, 3D [Freq=2.89GHz PhaseShift=0deg]
  Terminal S Parameter Chart1: St(A1[1,1]Patch_ProbeFed1_coax_pin_T1,A1[1,1]Patch_ProbeFed1_coax_pin_T1) on Setup1 : Sweep [Freq=all PhaseShift=all]
  Antenna Params Plot1: RadiationEfficiency vs Freq on Setup1 : Sweep [PhaseShift=all]
  Gain Plot - 2D: dB(GainTotal) vs Phi on Setup1 : LastAdaptive, 3D [Theta=90deg Freq=2.87222GHz]
